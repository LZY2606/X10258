* Left twin parameter revision
.INC ./inc/models.cir
.INC ./inc/cycle-a.cir
.PARAM TEMP_GAIN=5
XAMP1 NIN NBIAS VPWR 0 VOUT AMP GAIN='TEMP_GAIN+0' RP=10k WIDTH=4u
XAMP2 LEFT RIGHT PWR GND YOUT AMP GAIN=4 RP=10000 WIDTH=4000n
RLOAD VOUT 0 20k
CLOAD VOUT GND 2pF
.MODEL NMOS NMOS LEVEL=7 VERSION=2024.1
.MODEL PMOS PMOS LEVEL=7 VERSION=2024.1
