* B amplifier definition: alpha-renamed hierarchy and permuted symmetric devices
.SUBCKT AMP INP INB SUP GND OUTP GAIN=2 RP=10000
+ WIDTH=4000n
RP INP MID RP
RPB MID PAIR 1000
RPA MID PAIR 1000
QN OUTP MID SUP PMOS L='0.18u' W='GAIN*1u'
QP OUTP PAIR GND NMOS L='0.18u' W='GAIN*2u'
ZUNK INP INB OUTP MYPROP='RP/2'
.MODEL NMOS NMOS LEVEL=7 VERSION=2024.1
.MODEL PMOS PMOS LEVEL=7 VERSION=2024.1
.ENDS AMP
